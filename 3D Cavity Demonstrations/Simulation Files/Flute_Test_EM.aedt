# Ansys Electronics Desktop project, version 2020.1
materials:
  vacuum: permittivity=1

design Pan_pipe_Test (HFSS, Eigenmode, model units mm)
variables:
  Stock_L = -2in
  Stock_W = 0.625in
  Stock_H = 2.25in
geometry:
  Solid1 = imported_body(c:\_Lib\Automated-RF-Design-Demo-MASTER\3D Cavity Demonstrations\00000_single_mode_flute.stp)
  Box1 [vacuum] = box(corner=(0, 0, 0), size=(Stock_L, Stock_W, Stock_H))
  Box1.subtract(Solid1)
boundaries and excitations:
  Top_Imped: Impedance Faces=Box1.face(at (-9.64971, 7.9375, 0), at (-15.6822, 7.9375, 0), at (-21.7147, 7.9375, 0), at (-27.7472, 7.9375, 0), at (-33.7797, 7.9375, 0), at (-39.8122, 7.9375, 0)) Resistance=377 Reactance=0
  Bot_Imped: Impedance Faces=Box1.face(at (-12.666, 7.9375, 57.15), at (-18.6985, 7.9375, 57.15), at (-24.731, 7.9375, 57.15), at (-30.7635, 7.9375, 57.15), at (-36.796, 7.9375, 57.15)) Resistance=377 Reactance=0
setups:
  Test_EM: HfssEigen MinimumFrequency=2GHz NumModes=5 MaxDeltaFreq=0.1 ConvergeOnRealFreq=true MaximumPasses=10 MinimumPasses=1 MinimumConvergedPasses=1 PercentRefinement=30 BasisOrder=-1
source amplitudes:
  #-10:1: 1 0deg
  #-10:2..#-10:5: 0 0deg
field calculator expressions:
  E_energy_S_to_V = Fundamental_Quantity(0) | Mag | 2 | Pow | EnterSurface(AllObjects) | SurfaceValue | Integrate | Fundamental_Quantity(0) | Mag | 2 | Pow | EnterVolume(AllObjects) | VolumeValue | Integrate | /
  H_energy_S_to_V = <Hx,Hy,Hz> | Mag | 2 | Pow | EnterSurface(AllObjects) | SurfaceValue | Integrate | <Hx,Hy,Hz> | Mag | 2 | Pow | EnterVolume(AllObjects) | VolumeValue | Integrate | /
